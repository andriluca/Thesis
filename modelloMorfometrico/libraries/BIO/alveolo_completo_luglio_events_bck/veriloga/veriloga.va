// VerilogA for BIO, alveolo_veriloga, veriloga

`include "constants.vams"
`include "disciplines.vams"

module alveolo_completo_luglio_events_bck(enable, IN, OUT, triggerOUT, Vcharge);
input enable;
electrical enable;
inout IN, OUT;
electrical IN, OUT;

output triggerOUT;
electrical triggerOUT;

input Vcharge;
electrical Vcharge;

electrical nodeA, nodeB;

ground gnd;

parameter La = 1e-6, Lb=10e-6, Ra=1e-3, Rb=10e-3;

parameter Chargeth = 10e-6;
parameter Ccap = 1e-6;

parameter Vin_th = 1, Vgravity = 0;

parameter Lti = 1e-3, Rti = 1e-3, Cti = 1e-3, Rs = 1, Cs = 1e-6;

integer integration_en = 0, sw_state=1, swb_state = 1;

real Lvalue = 0, Rvalue = 0, Cvalue = 0, Rvalb = 0;
real threshold = 1;

real Vinteg = 0;

real charge = 0;

real chargeb = 0;

real thresholdb = 0.5;

real aux = 0;

real trigout = 0;

real Ctival = Cti, Csval = Cs, mult = 1;

analog begin

	@(cross(V(enable, gnd) - 0.5, +1)) begin
		integration_en = 1;
	end

	Vinteg = idt(integration_en*I(nodeA, OUT));

	charge = min(1, Vinteg/Chargeth);  //valore passato dal parametro
	chargeb = min(1, Vinteg/(1.5874e-4));  //valore fisso

	@(cross(chargeb - threshold, +1)) begin  //fine dell'integrazione della carica
		swb_state = 0;
	end

	@(cross(charge - threshold, +1)) begin  //cambio di valore delle Cti, Cs
		sw_state = 0;
	end

		V(triggerOUT, gnd) <+ transition (trigout, 0, 10n, 10n);

		aux = max(V(Vcharge, gnd), 1e-3);
		Rvalb =(Ra/aux);

	if (sw_state == 1)
		begin
		Lvalue = La+Lb*max(0,(1-charge));
		Rvalue = Rb*max(0,(1-charge))/aux;
		Ctival = Cti;
		Csval = Cs;
		end
	else
		begin
		Lvalue = La;
		Rvalue = 0;
		Ctival = Cti/3;
		Csval = Cs/3;
		end

	if (swb_state == 1)
		begin
		trigout = 0;
		Cvalue = max(1e-15, Ccap*chargeb);
		mult = 1;
		end
	else
		begin
		trigout = 1;
		Cvalue = Ccap;
		mult = 0.2;
		end

			V(IN, nodeA) <+ transition(V(enable, gnd)*sw_state*Vin_th + Vgravity, 0, 10u, 10u); // *restricted
			V (nodeA, OUT) <+  Lvalue*ddt(I(nodeA, OUT)) +(Rvalb + Rvalue)*I(nodeA, OUT);
			I(OUT, gnd) <+ Cvalue*ddt(V(OUT, gnd));
			V(OUT, nodeB) <+ Lti*ddt(I(OUT, nodeB)) + Rti*I(OUT, nodeB)+ idt(I(OUT, nodeB))/(transition(Ctival*mult, 0, 10u, 10u));
			I(nodeB, gnd) <+ V(nodeB, gnd)/Rs + transition(Csval*mult, 0, 10u, 10u)*ddt(V(nodeB, gnd));

end

endmodule
