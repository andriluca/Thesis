// VerilogA for BIO, vc_mirror, veriloga

`include "constants.vams"
`include "disciplines.vams"

module vc_mirror (inp, inn, outp, outn, vctrlp, vctrln);

inout inp, inn, outp, outn;
input vctrlp, vctrln;

electrical inp, inn, outp, outn, vctrlp, vctrln;

analog begin
	I(outp, outn) <+ I(inp, inn)*V(vctrlp,vctrln);
end

endmodule
