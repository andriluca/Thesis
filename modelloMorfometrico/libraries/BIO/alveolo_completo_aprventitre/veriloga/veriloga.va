// VerilogA for BIO, alveolo_veriloga, veriloga

`include "constants.vams"
`include "disciplines.vams"

module alveolo_completo_aprventitre(enable, IN, OUT, triggerOUT, Vcharge);

input enable;
electrical enable;
inout IN, OUT;
electrical IN, OUT;

output triggerOUT;
electrical triggerOUT;

input Vcharge;
electrical Vcharge;

electrical nodeA, nodeB, nodeCatodo;

ground gnd;

parameter La = 1e-6, Lb=10e-6, Ra=1e-3, Rb=10e-3;

parameter Chargeth = 10e-6;
parameter Ccap = 1e-6;

parameter Vin_th = 1, Vgravity = 0;
parameter Lti = 1e-3, Rti = 1e-3, Cti = 1e-3, Rs = 1, Cs = 1e-6;

integer integration_en = 0;

real Lvalue = 0, Rvalue = 0, Cvalue = 0, Rvalb = 0;
real threshold = 1;

real Vinteg = 0;

real VintegARIA = 0;

real charge = 0;

real chargeb = 0;

real chargec = 0;

real aux = 0;

real trigout = 0;

real temp = 1;

real Ctival = Cti, Csval = Cs, mult = 1, sw_state = 1;

real Vin_th2 = 0;

real th_swap = 0;

real diamIniz = 0.01;

analog begin

	@(cross(V(enable, gnd) - 0.5, +1)) begin
		integration_en = 1;
end

VintegARIA = idt(integration_en*I(nodeA, OUT));
Vinteg = idt(I(nodeA, OUT));

charge = min(1, max(0,VintegARIA/Chargeth));  //serve per R, l e cambio Vin_th e Vin_th2
chargec = min(1, max(0,VintegARIA/(2.5399e-4)));

//chargeb = max(0,((Vinteg - 1.27e-4)/(2.5399e-4-1.27e-4)));

chargeb = max(diamIniz,(((Vinteg - 1.27e-4)/(2.5399e-4-1.27e-4)*(1-diamIniz)+diamIniz)));

aux = min(1, chargeb);
temp = 1;  //modifica del 21 luglio

@(cross(chargec - threshold, +1)) begin //fine dell'integrazione della carica
trigout = 1;
sw_state = 0;
end

@(cross((charge -1), +1)) begin
th_swap = 1;
end

V(triggerOUT, gnd) <+ transition (trigout, 0, 10n, 10n);

Rvalb =(Ra/aux);

Lvalue = La+Lb*max(0,(1-charge));
Rvalue = (Rb/aux)*max(0,(1-charge));

Ctival = Cti/(temp); // va da Cti a Cti/15 quando ho raggiunto chargeb/2
Csval = Cs/(temp);// come sopra
Cvalue = max(1e-15, Ccap*chargec);

Vin_th2 = 0.08/(pow((3*max(VintegARIA/100, 1e-8))/(12.56), 1/3));

//I(IN, nodeCatodo) <+ 0.01*(exp(V(IN, nodeCatodo)))*(V(enable, gnd) - trigout) + V(IN, nodeCatodo)*1000*(1-V(enable, gnd)+trigout);

V(IN, nodeA) <+ V(enable, gnd)* Vin_th* transition ((1-th_swap), 0, 10u, 10u); // + Vgravity;
V (nodeA, OUT) <+ Lvalue*ddt(I(nodeA, OUT)) +(Rvalb + Rvalue)*I(nodeA, OUT) +  Vin_th2*transition (th_swap, 0, 10u, 10u);
I(OUT, gnd) <+ Cvalue*ddt(V(OUT, gnd));
V(OUT, nodeB) <+ Lti*ddt(I(OUT, nodeB)) + Rti*I(OUT, nodeB)+ idt(I(OUT, nodeB))/(transition(Ctival*mult, 0, 10u, 10u));
I(nodeB, gnd) <+ V(nodeB, gnd)/Rs + transition(Csval*mult, 0, 10u, 10u)*ddt(V(nodeB, gnd));

end

endmodule
