// VerilogA for BIO, alveolo_veriloga, veriloga

`include "constants.vams"
`include "disciplines.vams"

module alveolo_completo_veriloga(enable, IN, OUT, triggerOUT, Vcharge);
input enable;
electrical enable;
inout IN, OUT;
electrical IN, OUT; //, through;
electrical integration;
output triggerOUT;
electrical triggerOUT;

input Vcharge;
electrical Vcharge;

electrical nodeA, nodeB;//, nodeC;

ground gnd;

parameter La = 1e-6, Lb=10e-6, Ra=1e-3, Rb=10e-3;

parameter Chargeth = 10e-6;
parameter Ccap = 1e-6;

parameter Vin_th = 1, Vgravity = 0;

parameter Lti = 1e-3, Rti = 1e-3, Cti = 1e-3, Rs = 1, Cs = 1e-6;

integer integration_en = 0, sw_state=1;
//real delta = 0;
real Lvalue = 0, Rvalue = 0, Cvalue = 0, Rvalb = 0;
real threshold = 1;
real charge = 0;

real aux = 0;
//real trig = 0;

//real restricted = 0;

//real Vthreshold = 1;

analog begin

	if (V(enable)> 0.5)
		integration_en = 1;
	else
		begin
		integration_en = 0;
		end

	V(integration, gnd) <+ idt(integration_en*I(nodeA, OUT))/Chargeth;
	charge = min(1, V(integration, gnd));

	if (charge>=threshold)
		begin
		threshold = 0.5;
		sw_state = 0;
		V(triggerOUT, gnd) <+ 1;
		end
	else
		begin
		threshold = 1;
		sw_state = 1;
		V(triggerOUT, gnd) <+ 0;
		end

//		aux = max(V(Vcharge, gnd), 1e-6);
		aux = max(V(Vcharge, gnd), 1e-3);
		Rvalb =(Ra/aux);

	if (sw_state == 1)
		begin
		Lvalue = La+Lb*max(0,(1-charge));
		Rvalue = Rb*max(0,(1-charge));
        Cvalue = max(1e-15, Ccap*charge);
		end
	else
		begin
		Lvalue = La;
		Rvalue = 0;
		Cvalue = Ccap;
		end

//		V(triggerINT, triggerOUT) <+ I(triggerINT, triggerOUT)*1;

//		I(enable, gnd) <+ V(enable, gnd)*(1e-6);
//		I(Vcharge, gnd) <+ V(Vcharge, gnd)*(1e-6);

			V(IN, nodeA) <+ V(enable, gnd)*sw_state*Vin_th + Vgravity; // *restricted
			V (nodeA, OUT) <+  Lvalue*ddt(I(nodeA, OUT)) +(Rvalb + Rvalue)*I(nodeA, OUT);
//			I (nodeA, gnd) <+ Ccap*0.01 * ddt(V(nodeA, gnd));
			I(OUT, gnd) <+ Cvalue*ddt(V(OUT, gnd));
//			V(OUT, nodeB) <+  Cti*idt(I(OUT, nodeB));
			V(OUT, nodeB) <+ Lti*ddt(I(OUT, nodeB)) + Rti*I(OUT, nodeB)+ idt(I(OUT, nodeB))/Cti;
//			I(nodeB, nodeC) <+ Cti*ddt(V(nodeB, nodeC));
//			I(node, gnd) <+ V(nodeC, gnd)/Rs + Cs*ddt(V(nodeC, gnd));
			I(nodeB, gnd) <+ V(nodeB, gnd)/Rs + Cs*ddt(V(nodeB, gnd));

//			V (nodeA, through) <+  Lvalue*ddt(I(nodeA, through)) +(Rvalb + Rvalue)*I(nodeA, through);
//			I (nodeA, gnd) <+ Ccap*0.01 * ddt(V(nodeA, gnd));
//			V(through, OUT) <+ (Rvalb + Rvalue)*I(through, OUT) + Lvalue*ddt(I(through, OUT));
//			I(through, gnd) <+ ddt(Cvalue*V(through, gnd));
//			V(OUT, nodeB) <+ Lti*ddt(I(through, nodeB)) + Rti*I(through, nodeB) + Cti*idt(I(through, nodeB));
//			I(nodeB, gnd) <+ V(nodeB, gnd)/Rs + Cs*ddt(V(nodeB, gnd));

end

endmodule
