// VerilogA for BIO, integratore_limited, veriloga

`include "constants.vams"
`include "disciplines.vams"

module integratore_limited_lin_qtot_Th(enable, IN, through, OUT, triggerOUT, Vcharge);
input enable;
electrical enable;
inout IN, OUT, through;
electrical IN, OUT, through;
electrical integration;
output triggerOUT;
electrical triggerOUT;

input Vcharge;
electrical Vcharge;

ground gnd;

parameter La = 1e-6, Lb=10e-6, Ra=1e-3, Rb=10e-3, Rc=10e-3;

parameter Chargeth = 10e-6;
parameter Ccap = 1e-6;

parameter Vin_th = 1;

integer integration_en = 0, sw_state=1;
real delta = 0;
real Lvalue = 0, Rvalue = 0, Cvalue = 0, Rvalb = 0, Rser = 1e6, Rseries = 1e6;
real threshold = 1;
real charge = 0;

real aux = 0;
real trig = 0;

analog begin

	if (V(enable)> 0.5)
		integration_en = 1;
	else
		begin
		integration_en = 0;
		end

	V(integration, gnd) <+ idt(integration_en*I(IN, through))/Chargeth;
	charge = V(integration, gnd);

//	Rser = max(0.01, 10*Rb*(Vin_th - V(IN, gnd)) + max(0.01, 10*Rb*(0.9-V(enable, gnd))));
//	@(cross((V(IN, gnd)-Vin_th)*V(enable, gnd)- 0.05, +1))
	if ((V(IN, gnd) - Vin_th)*V(enable, gnd) > 0.01)
		Rser = 0;
	else
		begin
		Rser = 1e6;
		end

//	Rseries = transition(Rser, 0, 10u);
	Rseries = slew(Rser,1e7);

	if (charge>=threshold)
		begin
		//delta = 2;
		threshold = 0.5;
		sw_state = 0;
		V(triggerOUT, gnd) <+ 1;
//		trig = 1;
		end
	else
		begin
		//delta = 0;
		threshold = 1;
		sw_state = 1;
		V(triggerOUT, gnd) <+ 0;
//		trig = 0;
		end

//	@(cross(trig -0.5,0))
//	V(triggerOUT, gnd) <+ transition(trig,0,10u);

		aux = max(V(Vcharge, gnd), 1e-6);
		Rvalb = min(Rc, (Ra/aux));

	if (sw_state == 1)
		begin
	//	Lvalue = La+Lb*(1-charge);
	//	Rvalue = Ra+Rb*(1-charge);
    //  Cvalue = 1e-12 + Ccap*charge;
		Lvalue = La+Lb*max(0,(1-charge));
		Rvalue = Rb*max(0,(1-charge));
        Cvalue = max(1e-12, Ccap*charge);
		end
	else
		begin
		Lvalue = La;
		Rvalue = 0;
		Cvalue = Ccap;
		end

			V(IN, through) <+ Lvalue*ddt(I(IN, through)) +(Rvalb + Rvalue+ Rseries)*I(IN, through);
			V(through, OUT) <+ Lvalue*ddt(I(through, OUT)) + (Rvalb + Rvalue)*I(through, OUT);
			// shunt capacitor disabled
			I(through, gnd) <+ ddt(Cvalue*V(through, gnd));

end

endmodule
