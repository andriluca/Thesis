// VerilogA for BIO, cella_zwall, veriloga

`include "constants.vams"
`include "disciplines.vams"

module zwall_semplificato_veriloga(enable, IN, OUT, triggerOUT);

input enable;
electrical enable;
inout IN, OUT;
electrical IN, OUT, through;
electrical integration;
output triggerOUT;
electrical triggerOUT;

electrical nodeA, nodeC; //, nodeB;

ground gnd;

parameter La = 1e-6, Lb=10e-6, Ra=1e-3, Rb=10e-3, Rws = 1, Lws = 1e-3, Cws = 1e-6;

parameter Chargeth = 10e-6;
parameter Ccap = 1e-6;

parameter Vin_th = 1, Vgravity=0;

integer integration_en = 0, sw_state=1;
//real delta = 0;
real Lvalue = 0, Rvalue = 0, Cvalue = 0;
real threshold = 1;
real charge = 0;
//real trig = 0;

//real restricted = 0;

//real Vthreshold = 1;

real thresholdb = 0.5;

analog begin

	if (V(enable, gnd)> 0.5)
		integration_en = 1;
	else
		begin
		integration_en = 0;
		end

//	V(integration, gnd) <+ idt(integration_en*I(nodeA, through))/Chargeth;
	V(integration, gnd) <+ idt(integration_en*I(through, OUT))/Chargeth;
	charge = min(V(integration, gnd),1);

	if (charge>=threshold)
		begin
		threshold = 0.5;
		sw_state = 0;
		V(triggerOUT, gnd) <+ 1;
		end
	else
		begin
		threshold = 1;
		sw_state = 1;
		V(triggerOUT, gnd) <+ 0;
		end

	if (sw_state == 1)
		begin
		Lvalue = La+Lb*max(0,(1-charge));
		Rvalue = Ra+Rb*max(0,(1-charge));
        Cvalue = max(1e-12, Ccap*charge);
//		Cvalue = Ccap;
		end
	else
		begin
		Lvalue = La;
		Rvalue = Ra;
		Cvalue = 0;
		end

/*	if (charge>thresholdb)
		begin
		Cvalue = Ccap;
		thresholdb = 0.01;
		end
	else
		begin
		Cvalue = 0;
		end
*/

//	Cvalue = Ccap;

//		V(triggerINT, triggerOUT) <+ I(triggerINT, triggerOUT)*1;

//		I(enable, gnd) <+ V(enable, gnd)*(1e-6);
//		I(Vcharge, gnd) <+ V(Vcharge, gnd)/1e6;

		V(IN, nodeA) <+ V(enable, gnd)*sw_state*Vin_th + Vgravity; // *restricted
		V (nodeA, through) <+  Lvalue*ddt(I(nodeA, through)) +(Rvalue)*I(nodeA, through);
//		I (nodeA, gnd) <+ Ccap*0.01 * ddt(V(nodeA, gnd));

//		V (through, nodeB) <+ Rwc*I(through, nodeB) + Lwc*ddt(I(through, nodeB));
//		I (nodeB, gnd) <+ Cwc*ddt(V(nodeB, gnd));

//		V (through, nodeC) <+ Rws*I(through, nodeC) + Lws*ddt(I(through, nodeC));
//		I (nodeC, gnd) <+ Cws*ddt(V(nodeC, gnd));

//		I (through, nodeB) <+ Cwc*ddt(V(through, nodeB));
//		V (nodeB, gnd) <+ Rwc*I(nodeB, gnd) + Lwc*ddt(I(nodeB, gnd));

		I (through, nodeC) <+ Cws*ddt(V(through, nodeC));
		V (nodeC, gnd) <+ Rws*I(nodeC, gnd) + Lws*ddt(I(nodeC, gnd));

			V(through, OUT) <+ Rvalue*I(through, OUT) + Lvalue*ddt(I(through, OUT));
			I(through, gnd) <+ ddt(Cvalue*V(through, gnd));

end

endmodule
