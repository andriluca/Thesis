ADE simulation setup
Test BIO_polmone_simcomplete_qtot_1: BIO/polmone_simcomplete_qtot/schematic, simulator spectre
  Models: /software/DesignKits/UMC_A19/umc18cdmos/../Models/Spectre/cd18_120_v013.lib.scs[tt], /software/DesignKits/UMC_A19/umc18cdmos/../Models/Spectre/cd18_160_v062.lib.scs[tt], /software/DesignKits/UMC_A19/umc18cdmos/../Models/Spectre/cd18_160sa_v013.lib.scs[tt], /software/DesignKits/UMC_A19/umc18cdmos/../Models/Spectre/cd18_180_v052.lib.scs[tt], /software/DesignKits/UMC_A19/umc18cdmos/../Models/Spectre/cd18_18_v031.lib.scs[tt], /software/DesignKits/UMC_A19/umc18cdmos/../Models/Spectre/cd18_200_v052.lib.scs[tt], /software/DesignKits/UMC_A19/umc18cdmos/../Models/Spectre/cd18_240_v062.lib.scs[tt], /software/DesignKits/UMC_A19/umc18cdmos/../Models/Spectre/cd18_300_v072.lib.scs[tt], /software/DesignKits/UMC_A19/umc18cdmos/../Models/Spectre/cd18_400_v042.lib.scs[tt], /software/DesignKits/UMC_A19/umc18cdmos/../Models/Spectre/cd18_500_v052.lib.scs[tt], /software/DesignKits/UMC_A19/umc18cdmos/../Models/Spectre/cd18_50_iso_v0101.lib.scs[tt], /software/DesignKits/UMC_A19/umc18cdmos/../Models/Spectre/cd18_50_v051.lib.scs[tt], /software/DesignKits/UMC_A19/umc18cdmos/../Models/Spectre/cd18_600_v062.lib.scs[tt], /software/DesignKits/UMC_A19/umc18cdmos/../Models/Spectre/cd18_800_v014.lib.scs[tt], /software/DesignKits/UMC_A19/umc18cdmos/../Models/Spectre/cd18_dep50_iso_v014.lib.scs[tt], /software/DesignKits/UMC_A19/umc18cdmos/../Models/Spectre/cd18_diode_v041.lib.scs[tt], /software/DesignKits/UMC_A19/umc18cdmos/../Models/Spectre/cd18_diopw_v012.lib.scs[tt], /software/DesignKits/UMC_A19/umc18cdmos/../Models/Spectre/cd18_enh240_v014.lib.scs[tt], /software/DesignKits/UMC_A19/umc18cdmos/../Models/Spectre/cd18_enh300_v013.lib.scs[tt], /software/DesignKits/UMC_A19/umc18cdmos/../Models/Spectre/cd18_enh400_v015.lib.scs[tt], /software/DesignKits/UMC_A19/umc18cdmos/../Models/Spectre/cd18_hg_pnp_v041.lib.scs[tt], /software/DesignKits/UMC_A19/umc18cdmos/../Models/Spectre/cd18_hv_mimcap_v021.lib.scs[tt], /software/DesignKits/UMC_A19/umc18cdmos/../Models/Spectre/cd18_hvld_100_v014.lib.scs[tt], /software/DesignKits/UMC_A19/umc18cdmos/../Models/Spectre/cd18_hvld_120_v014.lib.scs[tt], /software/DesignKits/UMC_A19/umc18cdmos/../Models/Spectre/cd18_iso_18_v061.lib.scs[tt], /software/DesignKits/UMC_A19/umc18cdmos/../Models/Spectre/cd18_ldp_d600g50_v018.lib.scs[tt], /software/DesignKits/UMC_A19/umc18cdmos/../Models/Spectre/cd18_lvt50_v012.lib.scs[tt], /software/DesignKits/UMC_A19/umc18cdmos/../Models/Spectre/cd18_mimcap_v021.lib.scs[mimcaps_typ], /software/DesignKits/UMC_A19/umc18cdmos/../Models/Spectre/cd18_ncap18_v013.lib.scs[tt], /software/DesignKits/UMC_A19/umc18cdmos/../Models/Spectre/cd18_ncap50_v013.lib.scs[tt], /software/DesignKits/UMC_A19/umc18cdmos/../Models/Spectre/cd18_npn_v081.lib.scs[tt], /software/DesignKits/UMC_A19/umc18cdmos/../Models/Spectre/cd18_nvt18_v012.lib.scs[tt], /software/DesignKits/UMC_A19/umc18cdmos/../Models/Spectre/cd18_nvt50_v012.lib.scs[tt], /software/DesignKits/UMC_A19/umc18cdmos/../Models/Spectre/cd18_pnp_v041.lib.scs[tt], /software/DesignKits/UMC_A19/umc18cdmos/../Models/Spectre/cd18_res_v091.lib.scs[tt], /software/DesignKits/UMC_A19/umc18cdmos/../Models/Spectre/cd18_schottky_v015.lib.scs[tt], /software/DesignKits/UMC_A19/umc18cdmos/../Models/Spectre/cd18_zenerdiode_nw_v017.lib.scs[tt], /software/DesignKits/UMC_A19/umc18cdmos/../Models/Spectre/cd18_momcaps_v031.lib.scs[tt], /software/DesignKits/UMC_A19/umc18cdmos/../Models/Spectre/cd18e2_hp_v0391.lib.scs[tt], /home/enrico/Documents/BIO/modelli1406.scs
  Temperature: 27
  Analysis tran: stop=50 errpreset=moderate maxstep=10u strobeperiod=10m skipdc=yes
  Signals: /Vin, /enable, /Vchargein, /I32/p1 (terminal)
Run mode: Single Run, Sweeps and Corners
