ADE simulation setup
Run mode: Single Run, Sweeps and Corners
Tests:
  BIO_polmone_simcomplete_qtot_1: BIO/polmone_simcomplete_qtot/schematic, simulator spectre
