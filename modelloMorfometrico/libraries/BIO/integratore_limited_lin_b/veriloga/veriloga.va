// VerilogA for BIO, integratore_limited, veriloga

`include "constants.vams"
`include "disciplines.vams"

module integratore_limited_lin_b(enable, IN, through, OUT, triggerOUT);
input enable;
electrical enable;
inout IN, OUT, through;
electrical IN, OUT, through;
electrical integration;
output triggerOUT;
electrical triggerOUT;

electrical intA, intB;

ground gnd;

parameter La = 1e-6, Lb=10e-6, Ra=1e-3, Rb=10e-3, Rwc=1e-3, Lwc=1e-3, Cwc=1e-3, Rws=1e-3, Lws=1e-3, Cws=1e-3;

parameter Chargeth = 10e-6;
parameter Ccap = 1e-6;

integer integration_en = 0, sw_state=1;
real delta = 0;
real Lvalue = 0, Rvalue = 0, Cvalue = 0;
real threshold = 1;
real charge = 0;

analog begin

	if (V(enable)> 0.5)
		integration_en = 1;
	else
		begin
		integration_en = 0;
		end

	V(integration, gnd) <+ idt(integration_en*I(IN, through))/Chargeth;
	charge = V(integration, gnd);

	if (charge>=threshold)
		begin
		//delta = 2;
		threshold = 0.5;
		sw_state = 0;
		V(triggerOUT, gnd) <+ 1;
		end
	else
		begin
		//delta = 0;
		threshold = 1;
		sw_state = 1;
		V(triggerOUT, gnd) <+ 0;
		end

	if (sw_state == 1)
		begin
		Lvalue = La+Lb*max(0,(1-charge));
		Rvalue = Ra+Rb*max(0,(1-charge));
        Cvalue = max(1e-12, Ccap*charge);
		end
	else
		begin
		Lvalue = La;
		Rvalue = Ra;
		Cvalue = Ccap;
		end

			V(IN, through) <+ Lvalue*ddt(I(IN, through)) + Rvalue*I(IN, through);
			V(through, OUT) <+ Lvalue*ddt(I(through, OUT)) + Rvalue*I(through, OUT);
			// shunt capacitor disabled
			I(through, gnd) <+ ddt(Cvalue*V(through, gnd))+V(through, intA)/Rwc+V(through, intB)/Rws;
			V(intA, gnd) <+ Lwc*ddt(I(intA, gnd))+idt(I(intA, gnd))/Cwc;
			V(intB, gnd) <+ Lws*ddt(I(intB, gnd))+idt(I(intB, gnd))/Cws;

end

endmodule
